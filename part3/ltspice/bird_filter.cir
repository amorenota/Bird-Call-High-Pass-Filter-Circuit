*EECE 311 Fall 2025 design project - template for filtered audio file output

*input voltage source for noisy birds recording: node 1 is positive node of voltage source
V1 1 0 wavefile=wind_birds.wav AC 1

*********************************************

*Insert all nodes and elements for your filter circuit here

*Sallen-Key 1
C1 1 2 0.02u
C2 2 3 0.02u
R1 2 4 9.65k
R2 3 0 10.4k
X1 4 3 4 OPAMP

*Sallen-Key 2
C3 4 5 0.02u
C4 5 6 0.02u
R3 5 7 7.07k
R4 6 0 14.14k
X2 7 6 7 OPAMP

*Sallen-Key 3
C5 7 8 0.02u
C6 8 9 0.02u
R5 8 10 2.6k
R6 9 0 38.6k
X3 10 9 10 OPAMP

*Non-Inverting Op-Amp
R7 0 11 10k
R8 11 OUT 18.2k
X4 10 11 OUT OPAMP

*Don't forget the ".inc" commands for op-amp macromodels

.inc ideal_opamp.cir

*********************************************

*.wave command format: .wave <user-specified output file name> <# of bits per sample> <sampling rate> <output node>
*birds.wav file will be in same folder as this netlist, listen to playback with VLC Media Player or similar software
.wave birds.wav 16 44.1k V(OUT)

*run transient analysis for 18 seconds
.tran 18s

*set options for double-precision calculations and no compression for more accurate FFT analysis
.option plotwinsize=0
.option numdgt=7
