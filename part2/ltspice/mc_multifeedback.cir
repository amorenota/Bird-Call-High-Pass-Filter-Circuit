Monte-Carlo MultiFeedback HPF
V1 IN 0 AC 1

.param tol_C1 = 0.2
.param tol_C2 = 0.2
.param tol_C3 = 0.2

C1 IN 1 {MC(0.1u, tol_C1)}
C2 1 2 {MC(0.1u, tol_C2)}
C3 1 OUT {MC(0.1u, tol_C3)}

R1 1 0 4714
R2 OUT 2 21200

X1 0 2 OUT OPAMP

.INC ideal_opamp.cir
.step param run 1 500 1
.AC DEC 500 100 100k
