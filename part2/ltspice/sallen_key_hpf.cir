Sallen Key Netlist
V1 IN 0 AC 1

C1 IN 1 0.1u
C2 1 2 0.1u

R1 1 OUT 7171
R2 2 0 14142

X1 2 OUT OUT OPAMP

.INC ideal_opamp.cir
.AC DEC 500 100 100k
.END
